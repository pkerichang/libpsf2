// Design: adc_sampler_2/tran_test
simulator lang=spectre
global 0
parameters cap=1p res=1000 vdc=0.5
include "/tools/tstech16/CLN16FFC/PDK/tsmcN16/../models/toplevel.scs" section=top_tt

// adc_sampler_2/tran_test/schematic
C1 (vo2 0) capacitor c=cap
C0 (vo1 0) capacitor c=cap
R2 (0 vo2) resistor r=res
R1 (vo1 vo2) resistor r=res
R0 (vin vo1) resistor r=res
V0 (vin 0) vsource dc=vdc mag=1 type=pulse val0=0 val1=1 period=100n delay=100p rise=1p fall=1p width=50n
simulatorOptions options temp=27
tran tran stop=107n errpreset=conservative strobeperiod=10p
dcOp dc
dc dc param=vdc start=0 stop=1 lin=173
ac ac start=10e3 stop=100e9
save vin vo1 vo2 V0:p
saveOptions options save=selected
